** sch_path: /home/taka/ISHI_Kai/TokaiRIKA_TR10/Sanken_2026/TR-1um_MPW_Sanken/src/tr_1um_sanken.sch
.subckt tr_1um_sanken P1 VDD P2 P15 P14 P3 P4 P13 P5 P12 P6 P11 P10 P7 P9 VSS
*.PININFO P1:B P2:B P3:B P4:B P5:B P6:B P7:B VSS:B VDD:B P15:B P14:B P13:B P12:B P11:B P10:B P9:B
XR1 VDD P15 VDD F_RR w=2.8e-06 l=100e-06
XR2 VDD P14 VDD F_RR w=2.8e-06 l=100e-06
XR3 VDD P13 VDD F_RR w=2.8e-06 l=100e-06
XR4 VDD P12 VDD F_RR w=2.8e-06 l=100e-06
x2 VDD P15 SEL3N VSS INV_X1
x3 VDD SEL3N SEL3P VSS INV_X1
x4 VDD P14 SEL2N VSS INV_X1
x5 VDD SEL2N SEL2P VSS INV_X1
x6 VDD P13 SEL1N VSS INV_X1
x7 VDD SEL1N SEL1P VSS INV_X1
x8 VDD P12 SEL0N VSS INV_X1
x9 VDD SEL0N SEL0P VSS INV_X1
x42 VDD VSS net7 net1 net2 net6 net9 net5 net10 net4 net3 net8 ISHIKAI_INV
x10 SEL0P SEL1P VDD PJENF SEL3P SEL2P VSS AND4_X1
x11 SEL0N SEL1P VDD PJENE SEL3P SEL2P VSS AND4_X1
x12 SEL0P SEL1N VDD PJEND SEL3P SEL2P VSS AND4_X1
x13 SEL0N SEL1N VDD PJENC SEL3P SEL2P VSS AND4_X1
x14 SEL0P SEL1P VDD PJENB SEL3P SEL2N VSS AND4_X1
x15 SEL0N SEL1P VDD PJENA SEL3P SEL2N VSS AND4_X1
x16 SEL0P SEL1N VDD PJEN9 SEL3P SEL2N VSS AND4_X1
x17 SEL0N SEL1N VDD PJEN8 SEL3P SEL2N VSS AND4_X1
x18 SEL0P SEL1P VDD PJEN7 SEL3N SEL2P VSS AND4_X1
x19 SEL0N SEL1P VDD PJEN6 SEL3N SEL2P VSS AND4_X1
x20 SEL0P SEL1N VDD PJEN5 SEL3N SEL2P VSS AND4_X1
x21 SEL0N SEL1N VDD PJEN4 SEL3N SEL2P VSS AND4_X1
x22 SEL0P SEL1P VDD PJEN3 SEL3N SEL2N VSS AND4_X1
x23 SEL0N SEL1P VDD PJEN2 SEL3N SEL2N VSS AND4_X1
x24 SEL0P SEL1N VDD PJEN1 SEL3N SEL2N VSS AND4_X1
x25 SEL0N SEL1N VDD PJEN0 SEL3N SEL2N VSS AND4_X1
x1 P1 VDD P2 P15 P14 P3 P4 P13 P5 P12 P6 P11 P10 P7 P9 VSS OSS_FRAME
x28 VDD net14 net15 VSS net16 net17 fujii_inverter
x33 VDD net11 net13 VSS net12 mmIB1MP mmVB37 mmVB18 mmIB1MN mmVB12 mmOPAMP
x34 mmVB18 VSS mmIB1MP mmIB1MN mmVB37 mmVBG mmVB12 VDD mmBIAS
x43 VDD PJENF P1 net9 VSS ASWSL
x44 VDD PJENF P3 net7 VSS ASWSL
x45 VDD PJENF P5 net6 VSS ASWSL
x46 VDD PJENF P7 net8 VSS ASWSL
x47 VDD PJENF P10 net10 VSS ASWSL
x48 VDD PJENF net2 P2 VSS ASWS
x49 VDD PJENF net1 P4 VSS ASWS
x50 VDD PJENF net5 P6 VSS ASWS
x51 VDD PJENF net3 P9 VSS ASWS
x52 VDD PJENF net4 P11 VSS ASWS
x26 VDD PJENE P1 net14 VSS ASWSL
x27 VDD PJENE P3 net17 VSS ASWSL
x29 VDD PJENE net15 P2 VSS ASWS
x30 VDD PJENE net16 P4 VSS ASWS
x31 VDD PJEN4 P1 net11 VSS ASWSL
x32 VDD PJEN4 P2 net12 VSS ASWSL
x35 VDD PJEN4 net13 P3 VSS ASW
x36 VDD PJEN4 mmVBG P4 VSS ASWS
x37 VDD PJEN4 mmVB12 P5 VSS ASWS
x38 VDD PJEN4 mmVB18 P6 VSS ASWS
x39 VDD PJEN4 mmVB37 P7 VSS ASWS
x40 VDD PJEN4 mmIB1MP P9 VSS ASWS
x41 VDD PJEN4 mmIB1MN P10 VSS ASWS
x59 VDD PJEND P5 net18 VSS ASWSL
x61 VDD PJEND net19 P6 VSS ASWS
x58 VDD net18 net19 VSS kawamoto_inverter
x60 VDD PJENC P7 net20 VSS ASWSL
x62 VDD PJENC net21 P9 VSS ASWS
x63 VDD net20 net21 VSS kamiyama_inverter
.ends

* expanding   symbol:  TR-1um_5_stdcell/INV_X1.sym # of pins=4
** sym_path: /home/taka/pdk/TR-1um/libs.tech/xschem/TR-1um_5_stdcell/INV_X1.sym
** sch_path: /home/taka/pdk/TR-1um/libs.tech/xschem/TR-1um_5_stdcell/INV_X1.sch
.subckt INV_X1 VDD A Y GND
*.PININFO A:I Y:O GND:B VDD:B
MM7 Y A VDD VDD PMOS w=10.2u l=1u
MM2 Y A GND GND NMOS w=3.4u l=1u
.ends

* expanding   symbol:  ISHIKAI_INV.sym # of pins=12
** sym_path: /home/taka/ISHI_Kai/TokaiRIKA_TR10/Sanken_2026/TR-1um_MPW_Sanken/src/ISHIKAI_INV.sym
** sch_path: /home/taka/ISHI_Kai/TokaiRIKA_TR10/Sanken_2026/TR-1um_MPW_Sanken/src/ISHIKAI_INV.sch
.subckt ISHIKAI_INV VDD VSS INV_IN_2 INV_OUT_2 INV_OUT_1 INV_IN_3 INV_IN_1 INV_OUT_3 INV_IN_5 INV_OUT_5 INV_OUT_4 INV_IN_4
*.PININFO INV_IN_1:I INV_OUT_1:O VDD:B VSS:B INV_OUT_2:O INV_IN_2:I INV_IN_3:I INV_OUT_3:O INV_IN_4:I INV_OUT_4:O INV_IN_5:I
*+ INV_OUT_5:O
MM1 INV_OUT_1 INV_IN_1 VDD VDD PMOS w=3.4u l=1u
MM2 INV_OUT_1 INV_IN_1 VSS VSS NMOS w=3.4u l=1u
MXM1 INV_OUT_2 INV_IN_2 VDD VDD PMOS w=9u l=1u
MXM2 INV_OUT_2 INV_IN_2 VSS VSS NMOS w=3.4u l=1u
MM3 INV_OUT_3 INV_IN_3 VDD VDD PMOS w=3.4u l=1u
MM4 INV_OUT_3 INV_IN_3 VSS VSS NMOS w=3.4u l=1u
MM5 INV_OUT_4 INV_IN_4 VDD VDD PMOS w=3.4u l=1u m=3
MXM3 INV_OUT_4 INV_IN_4 VSS VSS NMOS w=3.4u l=1u
MXM4 INV_OUT_5 INV_IN_5 VDD VDD PMOS w=3.4u l=1u
MXM5 INV_OUT_5 INV_IN_5 VSS VSS NMOS w=3.4u l=1u
.ends

* expanding   symbol:  TR-1um_5_stdcell/AND4_X1.sym # of pins=7
** sym_path: /home/taka/pdk/TR-1um/libs.tech/xschem/TR-1um_5_stdcell/AND4_X1.sym
** sch_path: /home/taka/pdk/TR-1um/libs.tech/xschem/TR-1um_5_stdcell/AND4_X1.sch
.subckt AND4_X1 D C VDD Y A B GND
*.PININFO Y:O A:I B:I VDD:B GND:B C:I D:I
MM7 net1 A net4 GND NMOS w=3.4u l=1u
MM5 net3 C net2 GND NMOS w=3.4u l=1u
MM8 Y net1 GND GND NMOS w=3.4u l=1u
MM10 net2 D GND GND NMOS w=3.4u l=1u
MM6 net4 B net3 GND NMOS w=3.4u l=1u
MM11 net1 A VDD VDD PMOS w=10.2u l=1u
MM1 net1 D VDD VDD PMOS w=10.2u l=1u
MM3 net1 C VDD VDD PMOS w=10.2u l=1u
MM4 Y net1 VDD VDD PMOS w=10.2u l=1u
MM2 net1 B VDD VDD PMOS w=10.2u l=1u
.ends

* expanding   symbol:  OSS_FRAME.sym # of pins=16
** sym_path: /home/taka/ISHI_Kai/TokaiRIKA_TR10/Sanken_2026/TR-1um_MPW_Sanken/src/OSS_FRAME.sym
** sch_path: /home/taka/ISHI_Kai/TokaiRIKA_TR10/Sanken_2026/TR-1um_MPW_Sanken/src/OSS_FRAME.sch
.subckt OSS_FRAME P1 VDD P2 P15 P14 P3 P4 P13 P5 P12 P6 P11 P10 P7 P9 VSS
*.PININFO P1:B P2:B P3:B P4:B P5:B P6:B P7:B VSS:B VDD:B P15:B P14:B P13:B P12:B P11:B P10:B P9:B
x1 VDD P1 VSS OSS_ESD_5V_ANA
x2 VDD VSS OSS_ESD_5V_VDD
x3 VDD VSS OSS_ESD_5V_VSS
x4 VDD P2 VSS OSS_ESD_5V_ANA
x5 VDD P3 VSS OSS_ESD_5V_ANA
x6 VDD P4 VSS OSS_ESD_5V_ANA
x7 VDD P5 VSS OSS_ESD_5V_ANA
x8 VDD P6 VSS OSS_ESD_5V_ANA
x9 VDD P7 VSS OSS_ESD_5V_ANA
x10 VDD P15 VSS OSS_ESD_5V_ANA
x11 VDD P14 VSS OSS_ESD_5V_ANA
x12 VDD P13 VSS OSS_ESD_5V_ANA
x13 VDD P12 VSS OSS_ESD_5V_ANA
x14 VDD P11 VSS OSS_ESD_5V_ANA
x15 VDD P10 VSS OSS_ESD_5V_ANA
x16 VDD P9 VSS OSS_ESD_5V_ANA
.ends

* expanding   symbol:  fujii_inverter.sym # of pins=6
** sym_path: /home/taka/ISHI_Kai/TokaiRIKA_TR10/Sanken_2026/TR-1um_MPW_Sanken/src/fujii_inverter.sym
** sch_path: /home/taka/ISHI_Kai/TokaiRIKA_TR10/Sanken_2026/TR-1um_MPW_Sanken/src/fujii_inverter.sch
.subckt fujii_inverter VDD A Q VSS R B
*.PININFO A:I Q:O VDD:B VSS:B B:I R:O
MXM1 Q A VSS VSS NMOS w=4u l=1u
MXM2 Q A VDD VDD PMOS w=10u l=1u
MXM3 R B VSS VSS NMOS w=4u l=1u
MXM4 R B VDD VDD PMOS w=10u l=1u
MXM5 VDD VDD VDD VDD PMOS w=10u l=1u m=8
MXM6 VSS VSS VSS VSS NMOS w=4u l=1u m=8
.ends

* expanding   symbol:  mmOPAMP.sym # of pins=10
** sym_path: /home/taka/ISHI_Kai/TokaiRIKA_TR10/Sanken_2026/TR-1um_MPW_Sanken/src/mmOPAMP.sym
** sch_path: /home/taka/ISHI_Kai/TokaiRIKA_TR10/Sanken_2026/TR-1um_MPW_Sanken/src/mmOPAMP.sch
.subckt mmOPAMP VDD VINP VOUT VSS VINM IB1MP VB37 VB18 IB1MN VB12
*.PININFO VDD:B VSS:B VINM:I VINP:I VOUT:O IB1MP:I VB37:I VB18:I VB12:I IB1MN:I
MXM29 VDD VB18 MIb6D VSS NMOS w=20u l=1u m=2
MXM30 M8G VB37 MIb6D VSS NMOS w=20u l=1u m=2
MXMIb6 MIb6D IB1MN VSS VSS NMOS w=20u l=5u
MXM31 M8G M8G VDD VDD PMOS w=3.4u l=5u
MXM6 M5D M5D VDD VDD PMOS w=30u l=3u
MXM7 M1M2S M5D VDD VDD PMOS w=30u l=3u m=3
MXM8 M8D M8G M1M2S VDD PMOS w=45u l=1u m=2
MXM5 M5D VB12 M3M4S VSS NMOS w=15u l=1u m=2
MXM9 M8D M8D VSS VSS NMOS w=30u l=3u
MXM10 M3M4S M8D VSS VSS NMOS w=30u l=3u m=3
MXMIb4 M3M4S IB1MN VSS VSS NMOS w=20u l=5u m=2
MXM3 M3D VINM M3M4S VSS NMOS w=15u l=1u
MXM4 M4D VINP M3M4S VSS NMOS w=15u l=1u
MXM1 M1D VINM M1M2S VDD PMOS w=45u l=1u
MXM2 M2D VINP M1M2S VDD PMOS w=45u l=1u
MXMIb1 M1M2S IB1MP VDD VDD PMOS w=20u l=5u m=2
MXM17 M1D M27S VSS VSS NMOS w=7.5u l=1u m=4
MXM18 M2D M27S VSS VSS NMOS w=7.5u l=1u m=4
MXM15 M27S VB12 M1D VSS NMOS w=12.5u l=1u m=4
MXM16 M19S VB12 M2D VSS NMOS w=12.5u l=1u m=4
MXM27 M28S M19G M27S VSS NMOS w=5u l=1u m=4
MXM19 M20S M19G M19S VSS NMOS w=4u l=1u m=2
MXM28 M27S M20G M28S VDD PMOS w=15u l=1u m=4
MXM20 M19S M20G M20S VDD PMOS w=12u l=1u m=2
MXM13 M28S VB37 M3D VDD PMOS w=22.5u l=1u m=4
MXM14 M20S VB37 M4D VDD PMOS w=22.5u l=1u m=4
MXM11 M3D M28S VDD VDD PMOS w=22.5u l=1u m=4
MXM12 M4D M28S VDD VDD PMOS w=22.5u l=1u m=4
MXMIb2 M19G IB1MP VDD VDD PMOS w=17.5u l=5u m=4
MXM23 M19G M19G M24G VSS NMOS w=10u l=1u
MXM24 M24G M24G VSS VSS NMOS w=10u l=1u
MXMIb5 M20G IB1MN VSS VSS NMOS w=17.5u l=5u m=4
MXM21 M21G M21G VDD VDD PMOS w=15u l=1u m=2
MXM22 M20G M20G M21G VDD PMOS w=15u l=1u m=2
MXM25 VOUT M20S VDD VDD PMOS w=15u l=1u m=8
MXM26 VOUT M19S VSS VSS NMOS w=10u l=1u m=4
XXC1 M20S VOUT VSS F_CSIO x=36.1u y=90u A=3.249n P=252.2u
XXC2 VOUT M19S VSS F_CSIO x=90u y=36.1u A=3.249n P=252.2u
MXMIb6DMY1 VSS VSS net1 VSS NMOS w=20u l=5u
MXMIb6DMY2 MIb6D VSS net2 VSS NMOS w=20u l=5u
MXM29DMY MIb6D VSS net3 VSS NMOS w=20u l=1u
MXM30DMY MIb6D VSS net4 VSS NMOS w=20u l=1u
MXM31DMY1 net5 VDD VDD VDD PMOS w=3.4u l=5u
MXM31DMY2 net6 VDD M8G VDD PMOS w=3.4u l=5u
MXM9DMY M8D VSS net7 VSS NMOS w=30u l=3u
MXM10DMY M3M4S VSS net8 VSS NMOS w=30u l=3u
MXM6DMY net9 VDD M5D VDD PMOS w=30u l=3u
MXM7DMY net10 VDD M1M2S VDD PMOS w=30u l=3u
MXM8DMY1 net11 VDD M1M2S VDD PMOS w=45u l=1u
MXM8DMY2 net12 VDD M1M2S VDD PMOS w=45u l=1u
MXM5DMY2 M3M4S VSS net13 VSS NMOS w=15u l=1u
MXM5DMY1 M3M4S VSS net14 VSS NMOS w=15u l=1u
MXMIb1DMY2 net15 VDD VDD VDD PMOS w=20u l=5u
MXMIb1DMY1 net16 VDD VDD VDD PMOS w=20u l=5u
MXM2DMY net17 VDD M2D VDD PMOS w=45u l=1u
MXM1DMY net18 VDD M1D VDD PMOS w=45u l=1u
MXM3DMY M3D VSS net19 VSS NMOS w=15u l=1u
MXM4DMY M4D VSS net20 VSS NMOS w=15u l=1u
MXMIb4DMY2 VSS VSS net21 VSS NMOS w=20u l=5u
MXMIb4DMY1 VSS VSS net22 VSS NMOS w=20u l=5u
MXM11DMY net23 VDD VDD VDD PMOS w=22.5u l=1u
MXM11DMY2 net24 VDD VDD VDD PMOS w=22.5u l=1u
MXM13DMY1 net25 VDD M28S VDD PMOS w=22.5u l=1u
MXM13DMY2 net26 VDD M28S VDD PMOS w=22.5u l=1u
MXM28DMY1 net27 VDD M28S VDD PMOS w=15u l=1u
MXM28DMY2 net28 VDD M28S VDD PMOS w=15u l=1u
MXM27DMY2 M27S VSS net29 VSS NMOS w=5u l=1u
MXM27DMY1 M27S VSS net30 VSS NMOS w=5u l=1u
MXM15DMY1 M1D VSS net31 VSS NMOS w=12.5u l=1u
MXM15DMY2 M1D VSS net32 VSS NMOS w=12.5u l=1u
MXM17DMY1 M1D VSS net33 VSS NMOS w=7.5u l=1u
MXM17DMY2 M1D VSS net34 VSS NMOS w=7.5u l=1u
MXMIb2DMY1 net35 VDD VDD VDD PMOS w=17.5u l=5u
MXMIb2DMY2 net36 VDD VDD VDD PMOS w=17.5u l=5u
MXM23DMY2 M24G VSS net37 VSS NMOS w=10u l=1u
MXM23DMY1 M19G VSS net38 VSS NMOS w=10u l=1u
MXM24DMY2 VSS VSS net39 VSS NMOS w=10u l=1u
MXM24DMY1 M24G VSS net40 VSS NMOS w=10u l=1u
MXM21DMY2 net41 VDD VDD VDD PMOS w=15u l=1u
MXM21DMY1 net42 VDD VDD VDD PMOS w=15u l=1u
MXM22DMY2 net43 VDD M21G VDD PMOS w=15u l=1u
MXM22DMY1 net44 VDD M21G VDD PMOS w=15u l=1u
MXMIb5DMY2 VSS VSS net45 VSS NMOS w=17.5u l=5u
MXMIb5DMY1 VSS VSS net46 VSS NMOS w=17.5u l=5u
MXM25DMY1 net47 VDD VDD VDD PMOS w=15u l=1u
MXM25DMY2 net48 VDD VDD VDD PMOS w=15u l=1u
MXM26DMY2 VSS VSS net49 VSS NMOS w=10u l=1u
MXM26DMY1 VSS VSS net50 VSS NMOS w=10u l=1u
MXM18DMY1 M2D VSS net51 VSS NMOS w=7.5u l=1u
MXM18DMY2 M2D VSS net52 VSS NMOS w=7.5u l=1u
MXM16DMY1 M2D VSS net53 VSS NMOS w=12.5u l=1u
MXM16DMY2 M2D VSS net54 VSS NMOS w=12.5u l=1u
MXM19DMY2 M19S VSS net55 VSS NMOS w=4u l=1u
MXM19DMY1 M19S VSS net56 VSS NMOS w=4u l=1u
MXM20DMY1 net57 VDD M20S VDD PMOS w=12u l=1u
MXM20DMY2 net58 VDD M20S VDD PMOS w=12u l=1u
MXM14DMY1 net59 VDD M20S VDD PMOS w=22.5u l=1u
MXM14DMY2 net60 VDD M20S VDD PMOS w=22.5u l=1u
MXM12DMY1 net61 VDD VDD VDD PMOS w=22.5u l=1u
MXM12DMY2 net62 VDD VDD VDD PMOS w=22.5u l=1u
.ends

* expanding   symbol:  mmBIAS.sym # of pins=8
** sym_path: /home/taka/ISHI_Kai/TokaiRIKA_TR10/Sanken_2026/TR-1um_MPW_Sanken/src/mmBIAS.sym
** sch_path: /home/taka/ISHI_Kai/TokaiRIKA_TR10/Sanken_2026/TR-1um_MPW_Sanken/src/mmBIAS.sch
.subckt mmBIAS VB18 VSS IB1MP IB1MN VB37 VBG VB12 VDD
*.PININFO VDD:B VSS:B IB1MN:O IB1MP:O VB37:O VB18:O VB12:O VBG:O
MXM33 IB1MP IB1MP VDD VDD PMOS w=10u l=5u
MXM34 IB1MN IB1MN VSS VSS NMOS w=10u l=5u
MXM35 IB1MP IB1MN VSS VSS NMOS w=10u l=5u
MXM36 IB1MP STUPIG VSS VSS NMOS w=10u l=2u
MXM37 STUPIG M37G VSS VSS NMOS w=10u l=2u
MXM1 STUPVG M1G VDD VDD PMOS w=10u l=2u
MXM2 VBG0 STUPVG VDD VDD PMOS w=10u l=2u
MXM38 M38G M38G VDD VDD PMOS w=10u l=10u
MXM39 M38G IB1MN VSS VSS NMOS w=10u l=5u
MXM44 M44D M38G VDD VDD PMOS w=10u l=10u m=2
MXM46 VBG M38G VDD VDD PMOS w=10u l=10u m=5
MXM42 M42D VX M44D VDD PMOS w=20u l=2u m=4
MXM43 M41D VBE1 M44D VDD PMOS w=20u l=2u m=4
MXM40 M42D M42D VSS VSS NMOS w=10u l=2u m=2
MXM41 M41D M42D VSS VSS NMOS w=10u l=2u m=2
MXM45 VBG M41D VSS VSS NMOS w=10u l=2u m=8
MXM54 M54D M38G VDD VDD PMOS w=10u l=10u m=2
MXM56 VB37 M38G VDD VDD PMOS w=50u l=10u m=10
MXM52 M52S VB11 M54D VDD PMOS w=20u l=2u m=4
MXM53 M55G VBG M54D VDD PMOS w=20u l=2u m=4
MXM50 M52S M52S VSS VSS NMOS w=10u l=2u m=2
MXM51 M55G M52S VSS VSS NMOS w=10u l=2u m=2
MXM55 VB37 M55G VSS VSS NMOS w=32u l=2u m=25
XR51 VDD net1 VDD F_RR w=4e-6 l=76.9e-6
MXM32 IB1MN IB1MP M32S M32S PMOS w=40u l=5u
XR52 net1 net2 VDD F_RR w=4e-6 l=76.9e-6
XR53 net2 net3 VDD F_RR w=4e-6 l=76.9e-6
XR54 net3 net4 VDD F_RR w=4e-6 l=76.9e-6
XR55 net4 net5 VDD F_RR w=4e-6 l=76.9e-6
XR56 net5 net6 VDD F_RR w=4e-6 l=76.9e-6
XR57 net6 net7 VDD F_RR w=4e-6 l=76.9e-6
XR58 net7 net8 VDD F_RR w=4e-6 l=76.9e-6
XR59 net8 M32S VDD F_RR w=4e-6 l=76.9e-6
XR61 VDD net9 VDD F_RR w=2.8e-6 l=88.3e-6
XR62 net9 net10 VDD F_RR w=2.8e-6 l=88.3e-6
XR63 net10 net11 VDD F_RR w=2.8e-6 l=88.3e-6
XR64 net11 net12 VDD F_RR w=2.8e-6 l=88.3e-6
XR65 net12 net13 VDD F_RR w=2.8e-6 l=88.3e-6
XR66 net13 net14 VDD F_RR w=2.8e-6 l=88.3e-6
XR67 net14 net15 VDD F_RR w=2.8e-6 l=88.3e-6
XR68 net15 net16 VDD F_RR w=2.8e-6 l=88.3e-6
XR69 net16 net17 VDD F_RR w=2.8e-6 l=88.3e-6
XR610 net17 M37G VDD F_RR w=2.8e-6 l=88.3e-6
XR71 STUPIG net18 VDD F_RR w=2.8e-6 l=88.3e-6
XR72 net18 net19 VDD F_RR w=2.8e-6 l=88.3e-6
XR73 net19 net20 VDD F_RR w=2.8e-6 l=88.3e-6
XR74 net20 net21 VDD F_RR w=2.8e-6 l=88.3e-6
XR75 net21 M37G VDD F_RR w=2.8e-6 l=88.3e-6
XR171 STUPVG net22 VDD F_RR w=2.8e-6 l=88.3e-6
XR172 net22 net23 VDD F_RR w=2.8e-6 l=88.3e-6
XR173 net23 net24 VDD F_RR w=2.8e-6 l=88.3e-6
XR174 net24 net25 VDD F_RR w=2.8e-6 l=88.3e-6
XR175 net25 M1G VDD F_RR w=2.8e-6 l=88.3e-6
XR181 M1G net26 VDD F_RR w=2.8e-6 l=88.3e-6
XR182 net26 net27 VDD F_RR w=2.8e-6 l=88.3e-6
XR183 net27 net28 VDD F_RR w=2.8e-6 l=88.3e-6
XR184 net28 net29 VDD F_RR w=2.8e-6 l=88.3e-6
XR185 net29 net30 VDD F_RR w=2.8e-6 l=88.3e-6
XR186 net30 net31 VDD F_RR w=2.8e-6 l=88.3e-6
XR187 net31 net32 VDD F_RR w=2.8e-6 l=88.3e-6
XR188 net32 net33 VDD F_RR w=2.8e-6 l=88.3e-6
XR189 net33 net34 VDD F_RR w=2.8e-6 l=88.3e-6
XR1810 net34 VSS VDD F_RR w=2.8e-6 l=88.3e-6
XR141 VBG net35 VDD F_RR w=2.8e-6 l=92.7e-6
XR142 net35 net36 VDD F_RR w=2.8e-6 l=92.7e-6
XR143 net36 VBG0 VDD F_RR w=2.8e-6 l=92.7e-6
XR81 VBG0 net37 VDD F_RR w=2.8e-6 l=92.7e-6
XR82 net37 net38 VDD F_RR w=2.8e-6 l=92.7e-6
XR83 net38 net39 VDD F_RR w=2.8e-6 l=92.7e-6
XR84 net39 VBE1 VDD F_RR w=2.8e-6 l=92.7e-6
XR121 VBG0 net40 VDD F_RR w=2.8e-6 l=92.7e-6
XR122 net40 net41 VDD F_RR w=2.8e-6 l=92.7e-6
XR123 net41 net42 VDD F_RR w=2.8e-6 l=92.7e-6
XR124 net42 VX VDD F_RR w=2.8e-6 l=92.7e-6
XR131 VX net43 VDD F_RR w=4e-6 l=69.9e-6
XR132 net43 net44 VDD F_RR w=4e-6 l=69.9e-6
XR133 net44 VBE8 VDD F_RR w=4e-6 l=69.9e-6
DD1 VBE1 VSS DP A=12.96p P=14.4u
DD2 VBE8 VSS DP A=12.96p P=14.4u m=8
XXC1 VBG M41D VSS F_CSIO x=50u y=32.5u A=1.625n P=165u
XR101 VB11 net45 VDD F_RR w=2.8e-6 l=66.5e-6
XR102 net45 net46 VDD F_RR w=2.8e-6 l=66.5e-6
XR103 net46 VSS VDD F_RR w=2.8e-6 l=66.5e-6
XR91 VB37 net47 VDD F_RR w=2.8e-6 l=77.4e-6
XR92 net47 net48 VDD F_RR w=2.8e-6 l=77.4e-6
XR93 net48 net49 VDD F_RR w=2.8e-6 l=77.4e-6
XR94 net49 net50 VDD F_RR w=2.8e-6 l=77.4e-6
XR95 net50 net51 VDD F_RR w=2.8e-6 l=77.4e-6
XR96 net51 VB11 VDD F_RR w=2.8e-6 l=77.4e-6
XXC2 VB37 M55G VSS F_CSIO x=80u y=40.7u A=3.256n P=241.4u
XR111 VB37 net52 VDD F_RR w=4e-6 l=76.9e-6
XR191 VB18 VB12 VDD F_RR w=4e-6 l=73.2e-6
XR201 VB12 net53 VDD F_RR w=4e-6 l=73.2e-6
XR202 net53 VSS VDD F_RR w=4e-6 l=73.2e-6
XR112 net52 net54 VDD F_RR w=4e-6 l=76.9e-6
XR113 net54 VB18 VDD F_RR w=4e-6 l=76.9e-6
MXM36DMY IB1MP VSS net55 VSS NMOS w=10u l=2u
MXM37DMY STUPIG VSS net56 VSS NMOS w=10u l=2u
MXM33DMY1 net57 VDD VDD VDD PMOS w=10u l=5u
MXM33DMY2 net58 VDD IB1MP VDD PMOS w=10u l=5u
MXM32DMY1 net59 M32S M32S M32S PMOS w=20u l=5u
MXM32DMY2 net60 M32S M32S M32S PMOS w=20u l=5u
MXM34DMY IB1MN VSS net61 VSS NMOS w=10u l=5u
MXM35DMY IB1MP VSS net62 VSS NMOS w=10u l=5u
MXM1DMY net63 VDD STUPVG VDD PMOS w=10u l=2u
MXM2DMY net64 VDD VBG0 VDD PMOS w=10u l=2u
MXM38DMY1 net65 VDD VDD VDD PMOS w=10u l=10u
MXM38DMY2 net66 VDD M38G VDD PMOS w=10u l=10u
MXM44DMY1 net67 VDD VDD VDD PMOS w=10u l=10u
MXM44DMY2 net68 VDD VDD VDD PMOS w=10u l=10u
MXM42DMY net69 VDD M44D VDD PMOS w=20u l=2u
MXM43DMY net70 VDD M44D VDD PMOS w=20u l=2u
MXM39DMY1 M38G VSS net71 VSS NMOS w=10u l=5u
MXM39DMY2 VSS VSS net72 VSS NMOS w=10u l=5u
MXM40DMY VSS VSS net73 VSS NMOS w=10u l=2u
MXM41DMY VSS VSS net74 VSS NMOS w=10u l=2u
MXM46DMY2 net75 VDD VBG VDD PMOS w=10u l=10u
MXM46DMY1 net76 VDD VDD VDD PMOS w=10u l=10u
MXM45DMY1 VSS VSS net77 VSS NMOS w=10u l=2u
MXM45DMY2 VSS VSS net78 VSS NMOS w=10u l=2u
MXM50DMY VSS VSS net79 VSS NMOS w=10u l=2u
MXM51DMY VSS VSS net80 VSS NMOS w=10u l=2u
MXM52DMY net81 VDD M54D VDD PMOS w=20u l=2u
MXM53DMY net82 VDD M54D VDD PMOS w=20u l=2u
MXM54DMY2 net83 VDD VDD VDD PMOS w=10u l=10u
MXM54DMY1 net84 VDD VDD VDD PMOS w=10u l=10u
MXM55DMY1 VSS VSS net85 VSS NMOS w=32u l=2u
MXM55DMY2 VB37 VSS net86 VSS NMOS w=32u l=2u
MXM56DMY1 net87 VDD VDD VDD PMOS w=50u l=10u
MXM56DMY2 net88 VDD VDD VDD PMOS w=50u l=10u
MXM3 M37G VSS VSS VSS NMOS w=3.4u l=1u
MXM4 VBE1 VSS VSS VSS NMOS w=3.4u l=1u
MXM5 VX VSS VSS VSS NMOS w=3.4u l=1u
MXM6 VBG VSS VSS VSS NMOS w=3.4u l=1u
MXM7 VB11 VSS VSS VSS NMOS w=3.4u l=1u
MXM8 M1G VSS VSS VSS NMOS w=3.4u l=1u
.ends

* expanding   symbol:  ASWSL.sym # of pins=5
** sym_path: /home/taka/ISHI_Kai/TokaiRIKA_TR10/Sanken_2026/TR-1um_MPW_Sanken/src/ASWSL.sym
** sch_path: /home/taka/ISHI_Kai/TokaiRIKA_TR10/Sanken_2026/TR-1um_MPW_Sanken/src/ASWSL.sch
.subckt ASWSL VDD E A B VSS
*.PININFO E:I VDD:B VSS:B A:B B:B
MXM1 B net1 A VDD PMOS w=20u l=1u m=7
MXM2 A net2 B VSS NMOS w=8u l=1u m=7
MXM3 net1 E VDD VDD PMOS w=10.2u l=1u
MXM4 net1 E VSS VSS NMOS w=3.4u l=1u
MXM5 net2 net1 VDD VDD PMOS w=10.2u l=1u
MXM6 net2 net1 VSS VSS NMOS w=3.4u l=1u
MXM7 B net1 VSS VSS NMOS w=8u l=1u
.ends

* expanding   symbol:  ASWS.sym # of pins=5
** sym_path: /home/taka/ISHI_Kai/TokaiRIKA_TR10/Sanken_2026/TR-1um_MPW_Sanken/src/ASWS.sym
** sch_path: /home/taka/ISHI_Kai/TokaiRIKA_TR10/Sanken_2026/TR-1um_MPW_Sanken/src/ASWS.sch
.subckt ASWS VDD E A B VSS
*.PININFO E:I B:B VDD:B VSS:B A:B
MXM1 B net1 A VDD PMOS w=20u l=1u m=7
MXM2 A net2 B VSS NMOS w=8u l=1u m=7
MXM3 net1 E VDD VDD PMOS w=10.2u l=1u
MXM4 net1 E VSS VSS NMOS w=3.4u l=1u
MXM5 net2 net1 VDD VDD PMOS w=10.2u l=1u
MXM6 net2 net1 VSS VSS NMOS w=3.4u l=1u
.ends

* expanding   symbol:  ASW.sym # of pins=5
** sym_path: /home/taka/ISHI_Kai/TokaiRIKA_TR10/Sanken_2026/TR-1um_MPW_Sanken/src/ASW.sym
** sch_path: /home/taka/ISHI_Kai/TokaiRIKA_TR10/Sanken_2026/TR-1um_MPW_Sanken/src/ASW.sch
.subckt ASW VDD E A B VSS
*.PININFO E:I B:B VDD:B VSS:B A:B
MXM1 B net1 A VDD PMOS w=20u l=1u m=15
MXM2 A net2 B VSS NMOS w=8u l=1u m=15
MXM3 net1 E VDD VDD PMOS w=10.2u l=1u
MXM4 net1 E VSS VSS NMOS w=3.4u l=1u
MXM5 net2 net1 VDD VDD PMOS w=10.2u l=1u
MXM6 net2 net1 VSS VSS NMOS w=3.4u l=1u
.ends

* expanding   symbol:  kawamoto_inverter.sym # of pins=4
** sym_path: /home/taka/ISHI_Kai/TokaiRIKA_TR10/Sanken_2026/TR-1um_MPW_Sanken/src/kawamoto_inverter.sym
** sch_path: /home/taka/ISHI_Kai/TokaiRIKA_TR10/Sanken_2026/TR-1um_MPW_Sanken/src/kawamoto_inverter.sch
.subckt kawamoto_inverter VDD A Q VSS
*.PININFO A:I Q:O VSS:B VDD:B
MXM1 Q A VSS VSS NMOS w=4u l=1u
MXM2 Q A VDD VDD PMOS w=10u l=1u
.ends

* expanding   symbol:  kamiyama_inverter.sym # of pins=4
** sym_path: /home/taka/ISHI_Kai/TokaiRIKA_TR10/Sanken_2026/TR-1um_MPW_Sanken/src/kamiyama_inverter.sym
** sch_path: /home/taka/ISHI_Kai/TokaiRIKA_TR10/Sanken_2026/TR-1um_MPW_Sanken/src/kamiyama_inverter.sch
.subckt kamiyama_inverter VDD A Q VSS
*.PININFO A:I Q:O VDD:B VSS:B
MXM1 Q A VSS VSS NMOS w=4u l=1u
MXM2 Q A VDD VDD PMOS w=10u l=1u
.ends

* expanding   symbol:  OSS_ESD_5V_ANA.sym # of pins=4
** sym_path: /home/taka/ISHI_Kai/TokaiRIKA_TR10/Sanken_2026/TR-1um_MPW_Sanken/src/OSS_ESD_5V_ANA.sym
** sch_path: /home/taka/ISHI_Kai/TokaiRIKA_TR10/Sanken_2026/TR-1um_MPW_Sanken/src/OSS_ESD_5V_ANA.sch
.subckt OSS_ESD_5V_ANA VDD PAD VSS
*.PININFO PAD:B VDD:B VSS:B
MXM1 PAD VDD VDD VDD PMOS w=500u l=2u
MXM2 PAD VSS VSS VSS NMOSE w=500u l=2u
.ends

* expanding   symbol:  OSS_ESD_5V_VDD.sym # of pins=3
** sym_path: /home/taka/ISHI_Kai/TokaiRIKA_TR10/Sanken_2026/TR-1um_MPW_Sanken/src/OSS_ESD_5V_VDD.sym
** sch_path: /home/taka/ISHI_Kai/TokaiRIKA_TR10/Sanken_2026/TR-1um_MPW_Sanken/src/OSS_ESD_5V_VDD.sch
.subckt OSS_ESD_5V_VDD VDD VSS
*.PININFO VSS:B VDD:B VDD:B
MXM5 VSS VDD VDD VDD PMOS w=500u l=2u
MXM6 VDD VSS VSS VSS NMOSE w=500u l=2u
.ends

* expanding   symbol:  OSS_ESD_5V_VSS.sym # of pins=3
** sym_path: /home/taka/ISHI_Kai/TokaiRIKA_TR10/Sanken_2026/TR-1um_MPW_Sanken/src/OSS_ESD_5V_VSS.sym
** sch_path: /home/taka/ISHI_Kai/TokaiRIKA_TR10/Sanken_2026/TR-1um_MPW_Sanken/src/OSS_ESD_5V_VSS.sch
.subckt OSS_ESD_5V_VSS VDD VSS
*.PININFO VSS:B VDD:B VSS:B
MXM3 VSS VDD VDD VDD PMOS w=500u l=2u
MXM4 VDD VSS VSS VSS NMOSE w=500u l=2u
.ends
